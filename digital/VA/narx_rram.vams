// ----------------------------------------------------
//  NARX-based RRAM compact model (HSPICE-safe 3-file version)
//  - Main Shell File (auto-generated)
//  - numeric assignments: `include "narx_rram_assign.vams"
//  - unrolled math:       `include "narx_rram_unrolled_math.inc"
// ----------------------------------------------------
`include "constants.vams"
`include "disciplines.vams"

module narx_rram(g, s);
  inout g, s;
  electrical g, s;

  // ================== Parameters ==================
  parameter real Ts          = 1.0000000000000001e-09;
  parameter integer N_warmup = 40;
  parameter integer INIT_W   = 1;
  parameter real V_FILTER    = 1.0000000000000000e-02;
  parameter real Rref_min    = -2.0870411682128906e+02;
  parameter real Rref_max    = 2.0896453857421875e+02;

  parameter real tau_slew    = 2e-09 from [0:inf);
  parameter real R_clip_min  = 1.0000000000000000e+02;
  parameter real R_clip_max  = 1.0000000000000000e+08;
  parameter integer DBG      = 0;
  parameter real time_step   = 1.0000000000000001e-09;

  // ================== Sizes (모델 구조) ==================
  integer ny, z_dim, in_dim;
  integer hr_lr_in_dim, hr_lr_hid_dim;
  integer i, m; // for-loop 인덱스

  // ================== States / temps ==================
  real V_prev_raw;
  real dV, dir, rate;
  real I_hold;
  real I_pred;
  integer k_sample_total;
  integer k_eff;
  real R_last, G_last;

  // ================== Input / feature buffers ==================
  real x_raw[0:7];
  real x_scl[0:7];

  // ================== Scaler buffers (값은 assign에서 대입) ==================
  real mean_[0:7];
  real scale_[0:7];

  // ================== Weights / Biases (값은 assign에서 대입) ==================
  real bz_[0:63];
  real Wz_[0:511];
  real Wref_[0:63];
  real bref_;
  real Whr1_[0:2079];
  real bhr1_[0:31];
  real Whr2_[0:31];
  real bhr2_;
  real Wlr1_[0:2079];
  real blr1_[0:31];
  real Wlr2_[0:31];
  real blr2_;

  // ================== Network intermediates (unrolled가 써 넣음) ==================
  real z[0:63];
  real hr_h[0:31];
  real lr_h[0:31];

  // ================== Digital history ==================
  real W_hist[0:4];

  // ================== Outputs / temps ==================
  real r_ref_logit, v_scl, log_hr, log_lr;
  real hr_val, lr_val, alpha, R_pred;
  real W_next, Vgs;
  real alpha_slew;

  // --- 가중치/바이어스/스케일러 로드 (assign 키워드 없음) ---
  `include "narx_rram_assign.vams"

  analog begin
    $bound_step(Ts);

    @(initial_step("tran")) begin
      ny            = 5;
      z_dim         = 64;
      in_dim        = 8;
      hr_lr_in_dim  = 65;
      hr_lr_hid_dim = 32;

      V_prev_raw = V(g, s);
      I_hold     = 0.0;
      I_pred     = 0.0;
      R_last     = R_clip_min;
      G_last     = 1.0 / R_last;
      k_sample_total = 0;
      k_eff      = 0;

      // [수정] for (integer i=0...) -> for (i=0...)
      for (i = 0; i <= ny-1; i = i+1) W_hist[i] = INIT_W;

      if (DBG) $strobe("narx_rram: loaded (ny=%0d, z_dim=%0d, in_dim=%0d, V_FILTER=%g, tau_slew=%g)",
                        ny, z_dim, in_dim, V_FILTER, tau_slew);
    end

    // 출력: ZOH(+LPF)
    I(g, s) <+ I_hold;

    // 메인 업데이트
    @(timer(0, Ts)) begin
      Vgs = V(g, s);

      dV  = Vgs - V_prev_raw;
      dir = (dV > 0) ?  1 : ((dV < 0) ? -1 : 0);
      rate = abs(dV);

      alpha_slew = (tau_slew <= 0.0) ? 1.0 : (Ts / (tau_slew + Ts));
      if (alpha_slew > 1.0) alpha_slew = 1.0;
      else if (alpha_slew < 0.0) alpha_slew = 0.0;

      if (abs(Vgs) < V_FILTER) begin
        I_pred = Vgs * G_last;
        I_hold = I_hold + alpha_slew * (I_pred - I_hold);

        if (DBG) $strobe("SKIP  t=%g  V=%g  |V|<V_FILTER  -> I_read=%g (G_last=%g, k_eff=%0d)",
                          $abstime, Vgs, I_pred, G_last, k_eff);

        V_prev_raw = Vgs;
      end
      else begin
        x_raw[0] = Vgs;
        x_raw[1] = dir;
        x_raw[2] = rate;
        // [수정] for (integer i=0...) -> for (i=0...)
        for (i = 0; i <= ny-1; i = i+1) x_raw[i+3] = W_hist[i];

        // [수정] for (integer i=0...) -> for (i=0...)
        for (i = 0; i <= in_dim-1; i = i+1)
          x_scl[i] = (x_raw[i] - mean_[i]) / scale_[i];

        v_scl = x_scl[0];

        `include "narx_rram_unrolled_math.inc"

        hr_val = exp(log_hr);
        lr_val = exp(log_lr);

        alpha = (r_ref_logit - Rref_min) / (Rref_max - Rref_min);
        if (alpha < 0.0) alpha = 0.0;
        else if (alpha > 1.0) alpha = 1.0;

        R_pred = alpha * hr_val + (1.0 - alpha) * lr_val;
        if (R_pred < R_clip_min) R_pred = R_clip_min;
        if (R_pred > R_clip_max) R_pred = R_clip_max;

        I_pred = (R_pred != 0.0) ? (Vgs / R_pred) : 0.0;

        if (DBG) $strobe("INT t=%g | r_ref=%g log_hr=%g log_lr=%g",
                          $abstime, r_ref_logit, log_hr, log_lr);

        I_hold = I_hold + alpha_slew * (I_pred - I_hold);

        R_last = R_pred;
        G_last = 1.0 / R_last;

        W_next = (r_ref_logit > 0) ? 1 : 0;

        if (k_eff >= N_warmup) begin
          // [수정] for (integer m=...) -> for (m=...)
          for (m = ny-1; m >= 1; m = m-1)
            W_hist[m] = W_hist[m-1];
          W_hist[0] = W_next;
        end
        k_eff = k_eff + 1;

        if (DBG) $strobe("VALID t=%g V=%g dV=%g dir=%g rate=%g | alpha=%g  R=%g  I=%g  W0=%g  k_eff=%0d",
                          $abstime, Vgs, dV, dir, rate, alpha, R_pred, I_pred, W_hist[0], k_eff);

        V_prev_raw = Vgs;
      end

      k_sample_total = k_sample_total + 1;
    end
  end
endmodule
